* Calibration check: loop gain of the generic model with TPS62136 parameters,
* same injection and load as tps62136-3v8-loop.cir.
.param VIN=8.8 CO=30u FINJ=100k TSTART=0.4m TSTOP=0.6m
.include dcs-buck-generic.lib
VIN vin 0 {VIN}
XU vin sw vs fb 0 DCSBUCK params: TONSEL=2 KTON=250n PFM=0 RHS=0.1 RLS=0.039
+ ILIMH=5.6 ILIML=5.6 VREF=0.7 TOFFMIN=80n
L1 sw lx 1.5u
RL lx vout 14.3m
C1 vout 0 {CO}
Vinj vs vout SIN(0 10m {FINJ} {TSTART})
R1 vs fb 442k
R2 fb 0 100k
Cff vs fb 15p
Iload vout 0 1.6
.ic v(vout)=3.794 v(vs)=3.794
.tran 2n {TSTOP} 0 4n uic
.control
set wr_singlescale
set wr_vecnames
run
linearize v(vout) v(vs)
wrdata loop.dat v(vout) v(vs)
.endc
.end
